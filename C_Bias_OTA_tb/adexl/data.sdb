ADE simulation setup
Run mode: Single Run, Sweeps and Corners
Tests:
  Proyecto_Biasing:OTA_tb:1: cassini_tb/C_Bias_OTA_tb/schematic, simulator spectre
