ADE simulation setup
Run mode: Single Run, Sweeps and Corners
Tests:
  DC: cassini_tb/C_Bias_TOP_tb/schematic, simulator spectre
    Outputs: Vout [V]; Strong; SaturacionM1 [V]; WeakM1 [V]; SaturacionM2 [V]; WeakM2 [V]; SaturacionM3 [V]; SaturacionM4 [V]; StrongM3 [V]; StrongM4 [V]; SaturacionM5 [V]; SaturacionM6 [V]; SaturacionM7 [V]; SaturacionM8 [V]; StrongM5 [V]; StrongM6 [V]; StrongM7 [V]; StrongM8 [V]; SaturacionM9 [V]; SaturacionM10 [V]; SaturacionM11 [V]; SaturacionM12 [V]; StrongM9 [V]; StrongM10 [V]; StrongM11 [V]; StrongM12 [V]; SaturacionM13 [V]; StrongM13 [V]; Vth12; Iqscnt; I10u; Res; I1u; Rout; IDC("/I0/R0/PLUS"); IOUT; (- (OP("/I0/M13" "vds") - OP("/I0/M13" "vdsat"))); (- (OP("/M13" "vds") - OP("/M3t" "vdsat"))); saturacionM3t; (- (OP("/M3t" "vds") - OP("/M3t" "vdsat"))); saturacionM5t
  PM: cassini_tb/C_Bias_TOP_tb/schematic, simulator spectre
    Outputs: PM [gra]; GM [dB]
  PSRVOUT (off): Proyecto_Biasing/TOP_tb/config, simulator spectre
    Outputs: cross(PSRMag 10 nil nil); PSR_DC [dB]
  Tran (off): Proyecto_Biasing/TOP_tb/config, simulator spectre
    Outputs: v /I0/netVo; tran (V); itime('tran "/0/Vo"); itime('tran "/0/I0/I2/Vo"); itime('tran "/I0/I0/I2/R0/PLUS"); vtime('tran "/I0/I0/I2/R0/PLUS")
  PSRBG (off): Proyecto_Biasing/TOP_tb/config, simulator spectre
    Outputs: PSRBG_DC
  PSRCU (off): Proyecto_Biasing/TOP_tb/config, simulator spectre
    Outputs: PSR_DC_CU
  Noise2 (off): Proyecto_Biasing/TOP_tb/config, simulator spectre
    Outputs: (integ(NoiseF 0.001 157) * (1 / 121400.0)); Noise_Current
  PSRI1u: cassini_tb/C_Bias_TOP_tb/schematic, simulator spectre
    Outputs: PSR1DC
  PSRI10u: cassini_tb/C_Bias_TOP_tb/schematic, simulator spectre
    Outputs: value(PSR1 0.01); PSR10DC
  Noise1u: cassini_tb/C_Bias_TOP_tb/schematic, simulator spectre
    Outputs: Noise1U
  Noise10u: cassini_tb/C_Bias_TOP_tb/config, simulator spectre
    Outputs: Noise10U
Global variables:
  gain = 60
  lp = 2u
  Vm = 703m
  wp = 350n
  VDD = 1.8
  Rint = 2.4M
  Rc = 0
  Res = 96k
  Ohms = 1 (off)
  Rext = 121k
  Rtemp = 0
Corners (all switched off):
  model folders: /home/jrondon/myproject/virtuoso, /usr/local/tools/dkits/tsmc28/CMOS/HPC/pdk/A/tsmcN28/../models/spectre
  C0 (off): temperature=-40,125; VDD=1.62,1.98; Rext=120.9k, 121.1k; Rtemp=120m, 120.1m; toplevel.scs[ffh_lib ffl_lib fsh_lib fsl_lib fsn_lib sfh_lib sfl_lib sfn_lib ssh_lib ssl_lib ssn_lib], TOP_UP.pex
  C0_copy_0: temperature=-40,80; VDD=1.62,1.98; Rext=120.9k, 121.1k; Rtemp=120m; toplevel.scs[ffh_lib ffl_lib fsh_lib fsl_lib fsn_lib sfh_lib sfl_lib sfn_lib ssh_lib ssl_lib ssn_lib], TOP_UP.pex
  Stat_seq_200_Itrim_L (off): monteCarlo::param::donominal=1; monteCarlo::param::samplingMode="random"; monteCarlo::param::saveAllPlots=1; monteCarlo::param::saveMismatch=0; monteCarlo::param::saveProcess=1; monteCarlo::param::seed="12345"; monteCarlo::param::sequence=200; monteCarlo::param::totalPoints=200; monteCarlo::param::type="all"; not for DC, PM, PSRVOUT, Tran, PSRBG
  Stat_seq_1_Itrim_H (off): monteCarlo::param::donominal=1; monteCarlo::param::samplingMode="random"; monteCarlo::param::saveAllPlots=1; monteCarlo::param::saveMismatch=0; monteCarlo::param::saveProcess=1; monteCarlo::param::seed="12345"; monteCarlo::param::sequence=1; monteCarlo::param::totalPoints=200; monteCarlo::param::type="all"; not for DC, PM, PSRVOUT, Tran, PSRBG
  Montecarlo (off): toplevel.scs[globalMC_localMC_lib], TOP_UP.pex
  Copy_C0_145 (off): temperature=125; VDD=1.62; Rext=120.9k; toplevel.scs[ssl_lib]
  Copy_C0_132 (off): temperature=-40; VDD=1.62; Rext=121.1k; Rtemp=120m; toplevel.scs[ssh_lib]
  C0_copy_0_copy_0 (off): temperature=-40,80; VDD=1.62,1.98; Rext=120.9k, 121.1k; Rtemp=120m, 120.1m; toplevel.scs[ffh_lib ffl_lib fsh_lib fsl_lib fsn_lib sfh_lib sfl_lib sfn_lib ssh_lib ssl_lib ssn_lib], TOP_UP.pex
Specs:
  PSRVOUT / PSR_DC: < -60
  PM / PM: > 55
  PM / GM: > 10
  DC / WeakM1: > 0
  DC / SaturacionM1: > 0
  DC / SaturacionM2: > 0
  DC / WeakM2: > 0
  DC / SaturacionM3: > 0
  DC / SaturacionM4: > 0
  DC / StrongM3: > 0
  DC / StrongM4: > 0
  DC / SaturacionM5: > 0
  DC / SaturacionM6: > 0
  DC / SaturacionM7: > 0
  DC / SaturacionM8: > 0
  DC / StrongM7: > 0
  DC / StrongM8: > 0
  DC / SaturacionM9: > 0
  DC / SaturacionM10: > 0
  DC / SaturacionM11: > 0
  DC / SaturacionM12: > 0
  DC / StrongM9: > 0
  DC / StrongM10: > 0
  DC / StrongM11: > 0
  DC / StrongM12: > 0
  DC / SaturacionM13: > 0
  DC / StrongM5: > 0
  DC / StrongM6: > 0
  DC / StrongM13: < 0
  DC / I1u: range 0.967u to 1.0213u
  DC / I10u: range 9.78u to 10.132u
  DC / saturacionM3t: > 0
  DC / saturacionM5t: > 0
