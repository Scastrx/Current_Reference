ADE simulation setup
Run mode: Single Run, Sweeps and Corners
Tests:
  DC: cassini_tb/C_Bias_self_Bias_tb/schematic, simulator spectre
  Tran: cassini_tb/C_Bias_self_Bias_tb/schematic, simulator spectre
